** sch_path: /home/user/Desktop/myfolder/project/analog-circuit-dataset/synthetic/blocks/current_mirror_nmos.sch
**.subckt current_mirror_nmos
M1 iref_cmn iref_cmn GND GND nmos w=5u l=0.18u m=1
M2 iout_cmn iref_cmn GND GND nmos w=5u l=0.18u m=1
**.ends
.GLOBAL GND
.end
