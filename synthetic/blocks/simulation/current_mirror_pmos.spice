** sch_path: /home/user/Desktop/myfolder/project/analog-circuit-dataset/synthetic/blocks/current_mirror_pmos.sch
**.subckt current_mirror_pmos
M1 iout_cmp iref_cmp vdd vdd pmos w=5u l=0.18u m=1
M2 iref_cmp iref_cmp vdd vdd pmos w=5u l=0.18u m=1
**.ends
.end
