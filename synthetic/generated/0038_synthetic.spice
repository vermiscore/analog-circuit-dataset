* Synthetic circuit 0038
MN1 net6 net4 net8 GND nfet w=0.91u l=0.7u m=1
MN2 net6 net3 net5 GND nfet w=7.25u l=0.66u m=1
MN3 net5 net8 net8 GND nfet w=4.31u l=0.94u m=1
MN4 net2 net6 net9 GND nfet w=1.84u l=0.57u m=1
MP1 net1 net4 net7 vdd pfet w=7.36u l=0.92u m=1
MP2 net9 net1 vdd vdd pfet w=5.02u l=0.33u m=1
MP3 net3 GND net8 vdd pfet w=1.61u l=0.46u m=1
MP4 net3 net6 net6 vdd pfet w=9.15u l=0.54u m=1
.end
