** sch_path: /home/user/Desktop/myfolder/project/analog-circuit-dataset/synthetic/generated/0003_generated.sch
**.subckt 0003_generated
M1_0003_0 voutm_dpn_0003_0 vinp net1 GND nmos w=5u l=0.18u m=1
M2_0003_0 voutp_dpn_0003_0 vinm net1 GND nmos w=5u l=0.18u m=1
M3_0003_0 net1 vbn_dpn GND GND nmos w=5u l=0.18u m=1
M4_0003_0 voutp_dpn_0003_0 vinm net2 vdd pmos w=5u l=0.18u m=1
M5_0003_0 voutm_dpn_0003_0 vinp net2 vdd pmos w=5u l=0.18u m=1
M6_0003_0 net2 vbp_dpn vdd vdd pmos w=5u l=0.18u m=1
**.ends
.GLOBAL GND
.end
