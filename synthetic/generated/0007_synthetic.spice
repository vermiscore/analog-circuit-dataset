* Synthetic circuit 0007
MN1 net1 GND net6 GND nfet W=5.59u L=0.43u
MN2 net1 net2 GND GND nfet W=1.32u L=0.48u
MN3 net2 GND net4 GND nfet W=4.53u L=0.84u
MP1 net1 net2 net5 vdd pfet W=6.46u L=0.95u
MP2 net5 net5 vdd vdd pfet W=9.77u L=0.14u
R1 net1 net3 1000
R2 net1 GND 5000
R3 net3 net1 100
C1 net2 net2 1p
C2 GND net4 1p
.end
