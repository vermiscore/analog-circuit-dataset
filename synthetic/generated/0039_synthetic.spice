* Synthetic circuit 0039
MN1 net2 net5 net1 GND nfet w=7.42u l=0.1u m=1
MN2 net3 net4 net6 GND nfet w=7.25u l=0.96u m=1
MP1 net1 GND net3 vdd pfet w=3.98u l=0.2u m=1
MP2 net3 GND net4 vdd pfet w=8.74u l=0.56u m=1
MP3 net3 GND net2 vdd pfet w=4.87u l=0.33u m=1
R1 net4 net3 100
R2 vdd net5 200
R3 net6 net3 10000
.end
