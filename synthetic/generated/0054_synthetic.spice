* Synthetic circuit 0054
MN1 net4 ven net3 GND nmos w=4.74u l=0.62u m=1
MN2 net4 ven net1 GND nmos w=1.03u l=0.99u m=1
MP1 net5 net7 net3 vdd pmos w=1.36u l=0.41u m=1
MP2 net3 vg net4 vdd pmos w=5.67u l=0.19u m=1
MP3 net6 vg net2 vdd pmos w=9.85u l=0.63u m=1
MP4 net1 vin net4 vdd pmos w=3.94u l=0.1u m=1
R1 vdd net2 10000
R2 net1 net6 200
C1 vdd net3 1n
.end
