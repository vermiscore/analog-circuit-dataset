* Synthetic circuit 0012
MN1 net7 vdd net5 GND nfet W=5.08u L=0.68u
MN2 net8 net8 net3 GND nfet W=5.8u L=0.7u
MN3 net3 net6 net5 GND nfet W=2.04u L=0.92u
MN4 net1 net8 net3 GND nfet W=1.21u L=0.72u
MP1 net6 net5 net1 vdd pfet W=0.68u L=0.15u
MP2 net4 GND net6 vdd pfet W=9.49u L=0.2u
MP3 net7 net1 net8 vdd pfet W=3.47u L=0.66u
R1 net1 vdd 5000
R2 net1 net7 100
.end
