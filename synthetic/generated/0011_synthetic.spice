* Synthetic circuit 0011
MN1 net4 net1 net8 GND nfet W=5.02u L=0.65u
MN2 net3 GND net7 GND nfet W=3.38u L=0.18u
MN3 net1 net8 net6 GND nfet W=9.67u L=0.69u
MN4 net3 net8 GND GND nfet W=8.4u L=0.16u
MP1 net1 net2 net3 vdd pfet W=6.2u L=0.8u
MP2 net6 net6 net9 vdd pfet W=8.5u L=0.57u
MP3 net5 net6 vdd vdd pfet W=6.79u L=0.51u
MP4 net5 net5 net8 vdd pfet W=9.96u L=0.86u
R1 net3 net4 200
R2 net7 net3 100
R3 GND net8 100
C1 net5 net1 100p
C2 net5 net1 1p
.end
