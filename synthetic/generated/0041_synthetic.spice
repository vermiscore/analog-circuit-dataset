* Synthetic circuit 0041
MN1 net7 in net4 GND nmos w=3.13u l=0.87u m=1
MN2 net1 net1 net4 GND nmos w=4.67u l=0.24u m=1
MN3 net3 net3 net6 GND nmos w=2.95u l=0.72u m=1
MN4 net1 vbias net2 GND nmos w=0.81u l=0.88u m=1
MP1 net4 net6 net1 vdd pmos w=7.46u l=0.21u m=1
MP2 net1 net2 net2 vdd pmos w=9.18u l=0.72u m=1
MP3 net3 net5 vdd vdd pmos w=3.52u l=0.66u m=1
R1 net8 net1 1000
.end
