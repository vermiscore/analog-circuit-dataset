* Synthetic circuit 0051
MN1 net5 net3 net2 GND nmos w=5.71u l=0.52u m=1
MN2 net5 net1 net4 GND nmos w=6.07u l=0.42u m=1
MP1 net3 vin net4 vdd pmos w=8.6u l=0.13u m=1
MP2 net3 net4 vdd vdd pmos w=6.92u l=0.95u m=1
R1 net1 net4 500
.end
