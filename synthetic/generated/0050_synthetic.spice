* Synthetic circuit 0050
MN1 net4 net1 net8 GND nmos w=1.31u l=0.39u m=1
MN2 net2 net1 net3 GND nmos w=8.34u l=0.98u m=1
MN3 net6 ven net3 GND nmos w=1.15u l=0.88u m=1
MN4 net7 vbias net1 GND nmos w=7.08u l=0.84u m=1
MP1 net7 ven vdd vdd pmos w=3.71u l=0.82u m=1
MP2 net7 ven net1 vdd pmos w=9.15u l=0.34u m=1
MP3 net8 vg net2 vdd pmos w=6.42u l=0.58u m=1
R1 GND net6 10000
R2 net8 GND 10000
C1 net7 net6 1n
C2 net7 net8 10p
.end
